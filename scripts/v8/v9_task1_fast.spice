* Task 1 single-shot: real silicon OTA topology with NMOS-only differential pair + diode load.
* Approximates the chip's actual silicon (no PMOS).
* This gives a buffer with HIGH gain at low-mid freq, source-follower-like rolloff at high freq.

.lib /foss/pdks/sky130A/libs.tech/ngspice/sky130.lib.spice tt

VVDD VDPWR  GND 1.8
Vbn  Vbn_   GND 0.9
Vbmid Vbmid_ GND 0.9
* Input AC source
Vin     v_vna    GND  DC 0 AC 1
R_VNA   v_vna    v_pad1in 50
L_BOND1 v_pad1in v_pad1n  1.5e-9
R_BOND1 v_pad1n  v_pad1n2 0.05
C_PAD1  v_pad1n2 GND      125e-15
R_chip1 v_pad1n2 V1       0.5

* Tank 1 (V1)
L1 V1 nL1 1.351e-9
R1 nL1 VDPWR 5.0
C_T1 V1 GND  1.845p
C_SRF1 V1 GND 0.18p

* Tank 2 (V2_in)
L2 V2_in nL2 1.351e-9
R2 nL2 GND 5.0
C_T2 V2_in GND 0.836p
C_SRF2 V2_in GND 0.18p

* Mutual coupling
K_M12 L1 L2 -0.032

* AC coupling V1 → vin_p
Cac     V1     vin_p   14.112p
RbiasIn vin_p  Vbmid_  1e7

* === NMOS-only OTA approximating silicon (4 NFET cells) ===
* M_tail (Mb) — tail current source
XM_tail tail Vbn_ GND GND sky130_fd_pr__nfet_01v8 W=10 L=0.5 nf=4 m=5
* M1, M2 — input differential pair (split from Mf)
XM1 vd1 vin_p tail GND sky130_fd_pr__nfet_01v8 W=5 L=0.15 nf=8 m=5
XM2 vd2 Vfo tail GND sky130_fd_pr__nfet_01v8 W=5 L=0.15 nf=8 m=5
* Load: diode-connected NMOS (NMOS-only constraint)
XM3 vd1 vd1 VDPWR VDPWR sky130_fd_pr__nfet_01v8 W=10 L=0.5 nf=4 m=2
XM4 vd2 vd1 VDPWR VDPWR sky130_fd_pr__nfet_01v8 W=10 L=0.5 nf=4 m=2
* Source-follower output (Mout)
XM_sf VDPWR vd2 Vfo_int GND sky130_fd_pr__nfet_01v8 W=5 L=0.15 nf=8 m=5
* Output bias tail (Mout_b)
XM_obtail Vfo_int Vbn_ GND GND sky130_fd_pr__nfet_01v8 W=10 L=0.5 nf=4 m=2

* Tie Vfo to internal output node + decap
R_short Vfo_int Vfo 1
Rfb     Vfo    Vbmid_  1e7

* Forward coupling Vfo → V2_in
Cc      Vfo    V2_in   1.398p

* Type-2 perturbation
.param eps=0
Ceps    V1     V2_in   'max(2*1.845e-12*eps, 1e-21)'

* Output port
R_chip2 V2_in  v_pad2n  0.5
C_PAD2  v_pad2n GND    125e-15
L_BOND2 v_pad2n v_pad2  1.5e-9
R_load  v_pad2 GND      50

.end
