* v8 EP-TUNED deck — set C2 = C1 - Cc = 0.458 pF to satisfy β=1
* This is the THEORETICAL EP-tuned version (would require silicon changes)

.lib /foss/pdks/sky130A/libs.tech/ngspice/sky130.lib.spice tt

Vin     v_vna    GND  AC 1
R_VNA   v_vna    v_pad1in 50
L_BOND1 v_pad1in v_pad1n  1.5e-9
R_BOND1 v_pad1n  v_pad1n2 0.05
C_PAD1  v_pad1n2 GND      125e-15
R_chip1 v_pad1n2 V1       0.5

* Tank 1
L1 V1 nL1 1.351e-9
R1 nL1 0 5.0
C_T1 V1 GND  1.820e-12
C_SRF1 V1 GND 0.18e-12

* Tank 2 (EP-tuned: C2 = C1 - Cc - C_SRF2 difference)
L2 V2_in nL2 1.351e-9
R2 nL2 0 5.0
C_T2 V2_in GND 0.458e-12
C_SRF2 V2_in GND 0.18e-12

K_M12 L1 L2 -0.032

* IDEAL UNIDIRECTIONAL BUFFER: Vbuf = V1
E_buf Vbuf 0 V1 0 1.0

Cc      Vbuf    V2_in   1.362e-12

.param eps=0
Ceps    V1     V2_in   'max(2*1.820e-12*eps, 1e-21)'

R_chip2 V2_in  v_pad2n  0.5
C_PAD2  v_pad2n GND    125e-15
L_BOND2 v_pad2n v_pad2  1.5e-9
R_load  v_pad2  GND     50

.ac dec 8000 0.5e9 5e9
.end
